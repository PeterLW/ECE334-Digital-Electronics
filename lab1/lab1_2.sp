* FILE: lab1_2.sp

********************** begin header *****************************

* Sample Header file for Generic 2.5V 0.25 um process (g25)

.OPTIONS post ACCT OPTS lvltim=2
.OPTIONS post_version=9007

**################################################
* Only Typical/Typical models included
* NEED TO CHANGE ${MMI_TOOLS} TO BE PHYSICAL PATH
.include '/cad2/mmi_local/sue/g25.mod'
* NOTE: these are contrived spice models
**################################################

.param  arean(w,sdd) = '(w*sdd*1p)'
.param  areap(w,sdd) = '(w*sdd*1p)'
* Setup either one or the other of the following
* For ACM=0,2,10,12 fet models
.param  perin(w,sdd) = '(2u*(w+sdd))'
.param  perip(w,sdd) = '(2u*(w+sdd))'
* For ACM=3,13 fet models
*.param  perin(w,sdd) = '(1u*(w+2*sdd))'
*.param  perip(w,sdd) = '(1u*(w+2*sdd))'

.param ln_min   =  0.25u
.param lp_min   =  0.25u

* used in source/drain area/perimeter calculation
.param sdd        =  0.95

.PARAM vddp=2.5		$ VDD voltage

VDD vdd 0 DC vddp

.TEMP 105
.TRAN 10p 16n
*********************** end header ******************************

* SPICE netlist for "lab1_2" generated by MMI_SUE5.5.4 on Fri Sep 25
*+ 04:49:10 PM EDT 2015.

* start main CELL lab1_2
* .SUBCKT lab1_2 in_1 out
VVdd net_2 gnd DC 2.5
M_1 net_1 in_1 gnd gnd n W='2*1u' L=ln_min ad='arean(2,sdd)'
+ as='arean(2,sdd)' pd='perin(2,sdd)' ps='perin(2,sdd)'
M_2 net_1 in_1 net_2 vdd p W='4*1u' L=lp_min ad='areap(4,sdd)'
+ as='areap(4,sdd)' pd='perip(4,sdd)' ps='perip(4,sdd)'
VVdd_1 net_5 gnd DC 2.5
M_3 net_3 net_1 gnd gnd n W='2*1u' L=ln_min ad='arean(2,sdd)'
+ as='arean(2,sdd)' pd='perin(2,sdd)' ps='perin(2,sdd)'
M_4 net_3 net_1 net_5 vdd p W='4*1u' L=lp_min ad='areap(4,sdd)'
+ as='areap(4,sdd)' pd='perip(4,sdd)' ps='perip(4,sdd)'
VVdd_2 net_4 gnd DC 2.5
M_5 out net_3 gnd gnd n W='2*1u' L=ln_min ad='arean(2,sdd)'
+ as='arean(2,sdd)' pd='perin(2,sdd)' ps='perin(2,sdd)'
M_6 out net_3 net_4 vdd p W='4*1u' L=lp_min ad='areap(4,sdd)'
+ as='areap(4,sdd)' pd='perip(4,sdd)' ps='perip(4,sdd)'
* .ENDS	$ lab1_2

.GLOBAL gnd

.END
